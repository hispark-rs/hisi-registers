// Bootstrap source: PROVISIONAL bs2x-pac BS2X.svd snapshot 2026-07-17; fbb_bs2x is authoritative
// Imported once; this RDL is now reviewed canonical source.

addrmap bs2x_gadc_regs {
    reg {
        field {
            sw = rw;
            hw = r;
        } cfg_rstn_tst[0:0] = 0x0;
        field {
            sw = rw;
            hw = r;
        } cfg_gadc_rstn_bc[4:4] = 0x0;
        field {
            sw = rw;
            hw = r;
        } cfg_gadc_rstn_fc[8:8] = 0x0;
        field {
            sw = rw;
            hw = r;
        } cfg_gadc_rstn_data[12:12] = 0x0;
        field {
            sw = rw;
            hw = r;
        } cfg_gadc_rstn_ana[16:16] = 0x0;
    } CFG_RSTN @ 0x0;
    reg {
        field {
            sw = rw;
            hw = r;
        } cfg_clken_tst[0:0] = 0x0;
        field {
            sw = rw;
            hw = r;
        } cfg_gadc_clken_bc[4:4] = 0x0;
        field {
            sw = rw;
            hw = r;
        } cfg_gadc_clken_fc[8:8] = 0x0;
        field {
            sw = rw;
            hw = r;
        } cfg_gadc_clken_byp[12:12] = 0x0;
        field {
            sw = rw;
            hw = r;
        } cfg_gadc_clken_prechg[16:16] = 0x0;
        field {
            sw = rw;
            hw = r;
        } cfg_gadc_clken_ctrl[20:20] = 0x0;
    } CFG_CLKEN @ 0x4;
    reg {
        field {
            sw = rw;
            hw = r;
            desc = "Whole-register value; individual fields are not yet documented";
        } VALUE[31:0] = 0x0;
    } CFG_PRECHG_LEAD @ 0x8;
    reg {
        field {
            sw = rw;
            hw = r;
        } cfg_adc_ana_div_th[7:0] = 0x0;
        field {
            sw = rw;
            hw = r;
        } cfg_adc_ana_div_cyc[23:16] = 0x0;
    } CFG_CLK_DIV_0 @ 0xC;
    reg {
        field {
            sw = rw;
            hw = r;
        } ana_div_th[11:0] = 0x0;
        field {
            sw = rw;
            hw = r;
        } prechg_div_th[23:12] = 0x0;
    } CFG_CLK_DIV_1 @ 0x10;
    reg {
        field {
            sw = rw;
            hw = r;
            desc = "Whole-register value; individual fields are not yet documented";
        } VALUE[31:0] = 0x0;
    } CFG_MANUAL_CLK_0 @ 0x14;
    reg {
        field {
            sw = rw;
            hw = r;
            desc = "Whole-register value; individual fields are not yet documented";
        } VALUE[31:0] = 0x0;
    } CFG_MANUAL_CLK_1 @ 0x18;
    reg {
        field {
            sw = rw;
            hw = r;
            desc = "Whole-register value; individual fields are not yet documented";
        } VALUE[31:0] = 0x0;
    } CFG_ISO @ 0x1C;
    reg {
        field {
            sw = rw;
            hw = r;
            desc = "Whole-register value; individual fields are not yet documented";
        } VALUE[31:0] = 0x0;
    } CFG_GADC_CTRL_0 @ 0x30;
    reg {
        field {
            sw = rw;
            hw = r;
            desc = "Whole-register value; individual fields are not yet documented";
        } VALUE[31:0] = 0x0;
    } CFG_GADC_CTRL_1 @ 0x34;
    reg {
        field {
            sw = rw;
            hw = r;
            desc = "Whole-register value; individual fields are not yet documented";
        } VALUE[31:0] = 0x0;
    } CFG_GADC_CTRL_2 @ 0x38;
    reg {
        field {
            sw = rw;
            hw = r;
            desc = "Whole-register value; individual fields are not yet documented";
        } VALUE[31:0] = 0x0;
    } CFG_GADC_CTRL_3 @ 0x3C;
    reg {
        field {
            sw = rw;
            hw = r;
            desc = "Whole-register value; individual fields are not yet documented";
        } VALUE[31:0] = 0x0;
    } CFG_GADC_CTRL_4 @ 0x40;
    reg {
        field {
            sw = rw;
            hw = r;
            desc = "Whole-register value; individual fields are not yet documented";
        } VALUE[31:0] = 0x0;
    } RPT_GADC_CTRL_0 @ 0x44;
    reg {
        field {
            sw = rw;
            hw = r;
            desc = "Whole-register value; individual fields are not yet documented";
        } VALUE[31:0] = 0x0;
    } CFG_GADC_CTRL_5 @ 0x48;
    reg {
        field {
            sw = rw;
            hw = r;
            desc = "Whole-register value; individual fields are not yet documented";
        } VALUE[31:0] = 0x0;
    } CFG_GADC_CTRL_6 @ 0x4C;
    reg {
        field {
            sw = rw;
            hw = r;
            desc = "Whole-register value; individual fields are not yet documented";
        } VALUE[31:0] = 0x0;
    } RPT_GADC_CTRL_1 @ 0x50;
    reg {
        field {
            sw = rw;
            hw = r;
            desc = "Whole-register value; individual fields are not yet documented";
        } VALUE[31:0] = 0x0;
    } CFG_GADC_CTRL_7 @ 0x54;
    reg {
        field {
            sw = rw;
            hw = r;
            desc = "Whole-register value; individual fields are not yet documented";
        } VALUE[31:0] = 0x0;
    } RPT_GADC_CTRL_2 @ 0x58;
    reg {
        field {
            sw = rw;
            hw = r;
        } data_num[9:0] = 0x0;
        field {
            sw = rw;
            hw = r;
        } wait_num[14:12] = 0x0;
    } CFG_GADC_DATA_0 @ 0x5C;
    reg {
        field {
            sw = rw;
            hw = r;
        } osr_len[2:0] = 0x0;
        field {
            sw = rw;
            hw = r;
        } osr_sel[6:4] = 0x0;
        field {
            sw = rw;
            hw = r;
        } osr_wait_num[13:8] = 0x0;
    } CFG_GADC_DATA_1 @ 0x60;
    reg {
        field {
            sw = rw;
            hw = r;
            desc = "Whole-register value; individual fields are not yet documented";
        } VALUE[31:0] = 0x0;
    } RPT_GADC_DATA_0 @ 0x64;
    reg {
        field {
            sw = rw;
            hw = r;
            desc = "Whole-register value; individual fields are not yet documented";
        } VALUE[31:0] = 0x0;
    } RPT_GADC_DATA_1 @ 0x68;
    reg {
        field {
            sw = r;
            hw = r;
        } sample_data[17:0] = 0x0;
    } RPT_GADC_DATA_2 @ 0x6C;
    reg {
        field {
            sw = r;
            hw = r;
        } single_sample_done[0:0] = 0x0;
    } RPT_GADC_DATA_3 @ 0x70;
    reg {
        field {
            sw = rw;
            hw = r;
            desc = "Whole-register value; individual fields are not yet documented";
        } VALUE[31:0] = 0x0;
    } CFG_GADC_DATA_3 @ 0x74;
    reg {
        field {
            sw = rw;
            hw = r;
        } adc_cdac_fc_scale_div[8:0] = 0x0;
        field {
            sw = rw;
            hw = r;
        } adc_cdac_scale_div_sel[12:12] = 0x0;
    } CFG_GADC_DATA_4 @ 0x78;
    reg {
        field {
            sw = rw;
            hw = r;
            desc = "Whole-register value; individual fields are not yet documented";
        } VALUE[31:0] = 0x0;
    } RPT_GADC_DATA_4 @ 0x7C;
    reg {
        field {
            sw = rw;
            hw = r;
            desc = "Whole-register value; individual fields are not yet documented";
        } VALUE[31:0] = 0x0;
    } CFG_GADC_DATA_5 @ 0x80;
    reg {
        field {
            sw = rw;
            hw = r;
            desc = "Whole-register value; individual fields are not yet documented";
        } VALUE[31:0] = 0x0;
    } CFG_GADC_DATA_6 @ 0x84;
    reg {
        field {
            sw = rw;
            hw = r;
            desc = "Whole-register value; individual fields are not yet documented";
        } VALUE[31:0] = 0x0;
    } CFG_GADC_DATA_7 @ 0x88;
    reg {
        field {
            sw = rw;
            hw = r;
            desc = "Whole-register value; individual fields are not yet documented";
        } VALUE[31:0] = 0x0;
    } CFG_GADC_DATA_8 @ 0x8C;
    reg {
        field {
            sw = rw;
            hw = r;
            desc = "Whole-register value; individual fields are not yet documented";
        } VALUE[31:0] = 0x0;
    } CFG_GADC_DATA_9 @ 0x90;
    reg {
        field {
            sw = rw;
            hw = r;
            desc = "Whole-register value; individual fields are not yet documented";
        } VALUE[31:0] = 0x0;
    } CFG_GADC_DATA_10 @ 0x94;
    reg {
        field {
            sw = rw;
            hw = r;
            desc = "Whole-register value; individual fields are not yet documented";
        } VALUE[31:0] = 0x0;
    } CFG_GADC_DATA_11 @ 0x98;
    reg {
        field {
            sw = rw;
            hw = r;
            desc = "Whole-register value; individual fields are not yet documented";
        } VALUE[31:0] = 0x0;
    } CFG_GADC_DATA_12 @ 0x9C;
    reg {
        field {
            sw = rw;
            hw = r;
            desc = "Whole-register value; individual fields are not yet documented";
        } VALUE[31:0] = 0x0;
    } CFG_GADC_DATA_13 @ 0xA0;
    reg {
        field {
            sw = rw;
            hw = r;
            desc = "Whole-register value; individual fields are not yet documented";
        } VALUE[31:0] = 0x0;
    } CFG_GADC_DATA_14 @ 0xA4;
    reg {
        field {
            sw = rw;
            hw = r;
            desc = "Whole-register value; individual fields are not yet documented";
        } VALUE[31:0] = 0x0;
    } CFG_GADC_DATA_15 @ 0xA8;
    reg {
        field {
            sw = rw;
            hw = r;
            desc = "Whole-register value; individual fields are not yet documented";
        } VALUE[31:0] = 0x0;
    } CFG_GADC_DATA_16 @ 0xAC;
    reg {
        field {
            sw = rw;
            hw = r;
            desc = "Whole-register value; individual fields are not yet documented";
        } VALUE[31:0] = 0x0;
    } CFG_GADC_DATA_17 @ 0xB0;
    reg {
        field {
            sw = rw;
            hw = r;
            desc = "Whole-register value; individual fields are not yet documented";
        } VALUE[31:0] = 0x0;
    } CFG_GADC_DATA_18 @ 0xB4;
    reg {
        field {
            sw = rw;
            hw = r;
            desc = "Whole-register value; individual fields are not yet documented";
        } VALUE[31:0] = 0x0;
    } CFG_GADC_DATA_19 @ 0xB8;
    reg {
        field {
            sw = rw;
            hw = r;
            desc = "Whole-register value; individual fields are not yet documented";
        } VALUE[31:0] = 0x0;
    } CFG_GADC_DATA_20 @ 0xBC;
    reg {
        field {
            sw = rw;
            hw = r;
            desc = "Whole-register value; individual fields are not yet documented";
        } VALUE[31:0] = 0x0;
    } CFG_GADC_DATA_21 @ 0xC0;
    reg {
        field {
            sw = rw;
            hw = r;
            desc = "Whole-register value; individual fields are not yet documented";
        } VALUE[31:0] = 0x0;
    } CFG_GADC_DATA_22 @ 0xC4;
    reg {
        field {
            sw = rw;
            hw = r;
            desc = "Whole-register value; individual fields are not yet documented";
        } VALUE[31:0] = 0x0;
    } CFG_GADC_DATA_23 @ 0xC8;
    reg {
        field {
            sw = rw;
            hw = r;
            desc = "Whole-register value; individual fields are not yet documented";
        } VALUE[31:0] = 0x0;
    } CFG_GADC_DATA_24 @ 0xCC;
    reg {
        field {
            sw = rw;
            hw = r;
            desc = "Whole-register value; individual fields are not yet documented";
        } VALUE[31:0] = 0x0;
    } CFG_GADC_DATA_25 @ 0xD0;
    reg {
        field {
            sw = rw;
            hw = r;
            desc = "Whole-register value; individual fields are not yet documented";
        } VALUE[31:0] = 0x0;
    } RPT_GADC_DATA_5 @ 0xD4;
    reg {
        field {
            sw = rw;
            hw = r;
            desc = "Whole-register value; individual fields are not yet documented";
        } VALUE[31:0] = 0x0;
    } RPT_GADC_DATA_6 @ 0xD8;
    reg {
        field {
            sw = rw;
            hw = r;
            desc = "Whole-register value; individual fields are not yet documented";
        } VALUE[31:0] = 0x0;
    } RPT_GADC_DATA_7 @ 0xDC;
    reg {
        field {
            sw = rw;
            hw = r;
            desc = "Whole-register value; individual fields are not yet documented";
        } VALUE[31:0] = 0x0;
    } RPT_GADC_DATA_8 @ 0xE0;
    reg {
        field {
            sw = rw;
            hw = r;
            desc = "Whole-register value; individual fields are not yet documented";
        } VALUE[31:0] = 0x0;
    } RPT_GADC_DATA_9 @ 0xE4;
    reg {
        field {
            sw = rw;
            hw = r;
            desc = "Whole-register value; individual fields are not yet documented";
        } VALUE[31:0] = 0x0;
    } RPT_GADC_DATA_10 @ 0xE8;
    reg {
        field {
            sw = rw;
            hw = r;
            desc = "Whole-register value; individual fields are not yet documented";
        } VALUE[31:0] = 0x0;
    } RPT_GADC_DATA_11 @ 0xEC;
    reg {
        field {
            sw = rw;
            hw = r;
            desc = "Whole-register value; individual fields are not yet documented";
        } VALUE[31:0] = 0x0;
    } RPT_GADC_DATA_12 @ 0xF0;
    reg {
        field {
            sw = rw;
            hw = r;
            desc = "Whole-register value; individual fields are not yet documented";
        } VALUE[31:0] = 0x0;
    } RPT_GADC_DATA_13 @ 0xF4;
    reg {
        field {
            sw = rw;
            hw = r;
            desc = "Whole-register value; individual fields are not yet documented";
        } VALUE[31:0] = 0x0;
    } CFG_CMP_OS_0 @ 0x100;
    reg {
        field {
            sw = rw;
            hw = r;
            desc = "Whole-register value; individual fields are not yet documented";
        } VALUE[31:0] = 0x0;
    } CFG_CMP_OS_1 @ 0x104;
    reg {
        field {
            sw = rw;
            hw = r;
            desc = "Whole-register value; individual fields are not yet documented";
        } VALUE[31:0] = 0x0;
    } CFG_CMP_OS_2 @ 0x108;
    reg {
        field {
            sw = rw;
            hw = r;
            desc = "Whole-register value; individual fields are not yet documented";
        } VALUE[31:0] = 0x0;
    } CFG_CMP_OS_3 @ 0x10C;
    reg {
        field {
            sw = rw;
            hw = r;
            desc = "Whole-register value; individual fields are not yet documented";
        } VALUE[31:0] = 0x0;
    } CFG_CMP_OS_4 @ 0x110;
    reg {
        field {
            sw = rw;
            hw = r;
            desc = "Whole-register value; individual fields are not yet documented";
        } VALUE[31:0] = 0x0;
    } CFG_CMP_OS_5 @ 0x114;
    reg {
        field {
            sw = rw;
            hw = r;
            desc = "Whole-register value; individual fields are not yet documented";
        } VALUE[31:0] = 0x0;
    } CFG_CMP_OS_6 @ 0x118;
    reg {
        field {
            sw = rw;
            hw = r;
            desc = "Whole-register value; individual fields are not yet documented";
        } VALUE[31:0] = 0x0;
    } CFG_CMP_OS_7 @ 0x11C;
    reg {
        field {
            sw = rw;
            hw = r;
            desc = "Whole-register value; individual fields are not yet documented";
        } VALUE[31:0] = 0x0;
    } CFG_CMP_OS_8 @ 0x120;
    reg {
        field {
            sw = rw;
            hw = r;
            desc = "Whole-register value; individual fields are not yet documented";
        } VALUE[31:0] = 0x0;
    } CFG_CMP_OS_9 @ 0x124;
    reg {
        field {
            sw = rw;
            hw = r;
            desc = "Whole-register value; individual fields are not yet documented";
        } VALUE[31:0] = 0x0;
    } CFG_CMP_OS_10 @ 0x128;
    reg {
        field {
            sw = rw;
            hw = r;
            desc = "Whole-register value; individual fields are not yet documented";
        } VALUE[31:0] = 0x0;
    } RPT_CMP_OS_0 @ 0x12C;
    reg {
        field {
            sw = rw;
            hw = r;
            desc = "Whole-register value; individual fields are not yet documented";
        } VALUE[31:0] = 0x0;
    } CFG_CMP_OS_11 @ 0x130;
    reg {
        field {
            sw = rw;
            hw = r;
        } cfg_manual_cmp_os_code[6:0] = 0x0;
        field {
            sw = rw;
            hw = r;
        } cfg_manual_cmp_os_update[8:8] = 0x0;
    } CFG_CMP_OS_12 @ 0x134;
    reg {
        field {
            sw = rw;
            hw = r;
            desc = "Whole-register value; individual fields are not yet documented";
        } VALUE[31:0] = 0x0;
    } RPT_CMP_OS_2 @ 0x138;
    reg {
        field {
            sw = rw;
            hw = r;
            desc = "Whole-register value; individual fields are not yet documented";
        } VALUE[31:0] = 0x0;
    } CFG_CDAC_FC0_0 @ 0x150;
    reg {
        field {
            sw = rw;
            hw = r;
            desc = "Whole-register value; individual fields are not yet documented";
        } VALUE[31:0] = 0x0;
    } CFG_CDAC_FC0_1 @ 0x154;
    reg {
        field {
            sw = rw;
            hw = r;
            desc = "Whole-register value; individual fields are not yet documented";
        } VALUE[31:0] = 0x0;
    } CFG_CDAC_FC0_2 @ 0x158;
    reg {
        field {
            sw = rw;
            hw = r;
            desc = "Whole-register value; individual fields are not yet documented";
        } VALUE[31:0] = 0x0;
    } CFG_CDAC_FC0_3 @ 0x15C;
    reg {
        field {
            sw = rw;
            hw = r;
            desc = "Whole-register value; individual fields are not yet documented";
        } VALUE[31:0] = 0x0;
    } CFG_CDAC_FC0_4 @ 0x160;
    reg {
        field {
            sw = rw;
            hw = r;
            desc = "Whole-register value; individual fields are not yet documented";
        } VALUE[31:0] = 0x0;
    } CFG_CDAC_FC0_5 @ 0x164;
    reg {
        field {
            sw = rw;
            hw = r;
            desc = "Whole-register value; individual fields are not yet documented";
        } VALUE[31:0] = 0x0;
    } RPT_CDAC_FC0_0 @ 0x168;
    reg {
        field {
            sw = rw;
            hw = r;
            desc = "Whole-register value; individual fields are not yet documented";
        } VALUE[31:0] = 0x0;
    } CFG_CDAC_FC0_6 @ 0x16C;
    reg {
        field {
            sw = rw;
            hw = r;
            desc = "Whole-register value; individual fields are not yet documented";
        } VALUE[31:0] = 0x0;
    } CFG_CDAC_FC0_7 @ 0x170;
    reg {
        field {
            sw = rw;
            hw = r;
            desc = "Whole-register value; individual fields are not yet documented";
        } VALUE[31:0] = 0x0;
    } CFG_CDAC_FC0_8 @ 0x174;
    reg {
        field {
            sw = rw;
            hw = r;
            desc = "Whole-register value; individual fields are not yet documented";
        } VALUE[31:0] = 0x0;
    } CFG_CDAC_FC0_9 @ 0x178;
    reg {
        field {
            sw = rw;
            hw = r;
            desc = "Whole-register value; individual fields are not yet documented";
        } VALUE[31:0] = 0x0;
    } CFG_CDAC_FC0_10 @ 0x17C;
    reg {
        field {
            sw = rw;
            hw = r;
            desc = "Whole-register value; individual fields are not yet documented";
        } VALUE[31:0] = 0x0;
    } CFG_CDAC_FC0_11 @ 0x180;
    reg {
        field {
            sw = rw;
            hw = r;
            desc = "Whole-register value; individual fields are not yet documented";
        } VALUE[31:0] = 0x0;
    } CFG_CDAC_FC0_12 @ 0x184;
    reg {
        field {
            sw = rw;
            hw = r;
            desc = "Whole-register value; individual fields are not yet documented";
        } VALUE[31:0] = 0x0;
    } CFG_CDAC_FC0_13 @ 0x188;
    reg {
        field {
            sw = rw;
            hw = r;
            desc = "Whole-register value; individual fields are not yet documented";
        } VALUE[31:0] = 0x0;
    } CFG_CDAC_FC0_14 @ 0x18C;
    reg {
        field {
            sw = rw;
            hw = r;
            desc = "Whole-register value; individual fields are not yet documented";
        } VALUE[31:0] = 0x0;
    } CFG_CDAC_FC1_0 @ 0x190;
    reg {
        field {
            sw = rw;
            hw = r;
            desc = "Whole-register value; individual fields are not yet documented";
        } VALUE[31:0] = 0x0;
    } CFG_CDAC_FC1_1 @ 0x194;
    reg {
        field {
            sw = rw;
            hw = r;
            desc = "Whole-register value; individual fields are not yet documented";
        } VALUE[31:0] = 0x0;
    } CFG_CDAC_FC1_2 @ 0x198;
    reg {
        field {
            sw = rw;
            hw = r;
            desc = "Whole-register value; individual fields are not yet documented";
        } VALUE[31:0] = 0x0;
    } CFG_CDAC_FC1_3 @ 0x19C;
    reg {
        field {
            sw = rw;
            hw = r;
            desc = "Whole-register value; individual fields are not yet documented";
        } VALUE[31:0] = 0x0;
    } RPT_CDAC_FC1_0 @ 0x1A0;
    reg {
        field {
            sw = rw;
            hw = r;
            desc = "Whole-register value; individual fields are not yet documented";
        } VALUE[31:0] = 0x0;
    } RPT_CDAC_FC1_3 @ 0x1A4;
    reg {
        field {
            sw = rw;
            hw = r;
            desc = "Whole-register value; individual fields are not yet documented";
        } VALUE[31:0] = 0x0;
    } RPT_CDAC_FC3_1 @ 0x1A8;
    reg {
        field {
            sw = rw;
            hw = r;
            desc = "Whole-register value; individual fields are not yet documented";
        } VALUE[31:0] = 0x0;
    } RPT_CDAC_FC3_2 @ 0x1AC;
    reg {
        field {
            sw = rw;
            hw = r;
            desc = "Whole-register value; individual fields are not yet documented";
        } VALUE[31:0] = 0x0;
    } RPT_CDAC_FC3_3 @ 0x1B0;
    reg {
        field {
            sw = rw;
            hw = r;
            desc = "Whole-register value; individual fields are not yet documented";
        } VALUE[31:0] = 0x0;
    } RPT_CDAC_FC3_4 @ 0x1B4;
    reg {
        field {
            sw = rw;
            hw = r;
            desc = "Whole-register value; individual fields are not yet documented";
        } VALUE[31:0] = 0x0;
    } RPT_CDAC_FC3_5 @ 0x1B8;
    reg {
        field {
            sw = rw;
            hw = r;
            desc = "Whole-register value; individual fields are not yet documented";
        } VALUE[31:0] = 0x0;
    } RPT_CDAC_FC3_6 @ 0x1BC;
    reg {
        field {
            sw = rw;
            hw = r;
            desc = "Whole-register value; individual fields are not yet documented";
        } VALUE[31:0] = 0x0;
    } RPT_CDAC_FC3_7 @ 0x1C0;
    reg {
        field {
            sw = rw;
            hw = r;
            desc = "Whole-register value; individual fields are not yet documented";
        } VALUE[31:0] = 0x0;
    } RPT_CDAC_FC3_8 @ 0x1C4;
    reg {
        field {
            sw = rw;
            hw = r;
            desc = "Whole-register value; individual fields are not yet documented";
        } VALUE[31:0] = 0x0;
    } RPT_CDAC_FC3_9 @ 0x1C8;
    reg {
        field {
            sw = rw;
            hw = r;
            desc = "Whole-register value; individual fields are not yet documented";
        } VALUE[31:0] = 0x0;
    } RPT_CDAC_FC3_10 @ 0x1CC;
    reg {
        field {
            sw = rw;
            hw = r;
            desc = "Whole-register value; individual fields are not yet documented";
        } VALUE[31:0] = 0x0;
    } RPT_CDAC_FC3_11 @ 0x1D0;
    reg {
        field {
            sw = rw;
            hw = r;
            desc = "Whole-register value; individual fields are not yet documented";
        } VALUE[31:0] = 0x0;
    } RPT_CDAC_FC3_12 @ 0x1D4;
    reg {
        field {
            sw = rw;
            hw = r;
            desc = "Whole-register value; individual fields are not yet documented";
        } VALUE[31:0] = 0x0;
    } RPT_CDAC_FC3_13 @ 0x1D8;
    reg {
        field {
            sw = rw;
            hw = r;
            desc = "Whole-register value; individual fields are not yet documented";
        } VALUE[31:0] = 0x0;
    } RPT_CDAC_FC3_14 @ 0x1DC;
    reg {
        field {
            sw = rw;
            hw = r;
            desc = "Whole-register value; individual fields are not yet documented";
        } VALUE[31:0] = 0x0;
    } RPT_CDAC_FC3_15 @ 0x1E0;
    reg {
        field {
            sw = rw;
            hw = r;
            desc = "Whole-register value; individual fields are not yet documented";
        } VALUE[31:0] = 0x0;
    } RPT_CDAC_FC3_16 @ 0x1E4;
    reg {
        field {
            sw = rw;
            hw = r;
            desc = "Whole-register value; individual fields are not yet documented";
        } VALUE[31:0] = 0x0;
    } RPT_CDAC_FC3_17 @ 0x1E8;
    reg {
        field {
            sw = rw;
            hw = r;
            desc = "Whole-register value; individual fields are not yet documented";
        } VALUE[31:0] = 0x0;
    } RPT_CDAC_FC3_18 @ 0x1EC;
    reg {
        field {
            sw = rw;
            hw = r;
            desc = "Whole-register value; individual fields are not yet documented";
        } VALUE[31:0] = 0x0;
    } CFG_DCOC_CAL_0 @ 0x200;
    reg {
        field {
            sw = rw;
            hw = r;
            desc = "Whole-register value; individual fields are not yet documented";
        } VALUE[31:0] = 0x0;
    } CFG_DCOC_CAL_1 @ 0x204;
    reg {
        field {
            sw = rw;
            hw = r;
            desc = "Whole-register value; individual fields are not yet documented";
        } VALUE[31:0] = 0x0;
    } CFG_DCOC_CAL_2 @ 0x208;
    reg {
        field {
            sw = rw;
            hw = r;
            desc = "Whole-register value; individual fields are not yet documented";
        } VALUE[31:0] = 0x0;
    } CFG_DCOC_CAL_3 @ 0x20C;
    reg {
        field {
            sw = rw;
            hw = r;
            desc = "Whole-register value; individual fields are not yet documented";
        } VALUE[31:0] = 0x0;
    } CFG_DCOC_CAL_4 @ 0x210;
    reg {
        field {
            sw = rw;
            hw = r;
            desc = "Whole-register value; individual fields are not yet documented";
        } VALUE[31:0] = 0x0;
    } CFG_DCOC_CAL_5 @ 0x214;
    reg {
        field {
            sw = rw;
            hw = r;
            desc = "Whole-register value; individual fields are not yet documented";
        } VALUE[31:0] = 0x0;
    } CFG_DCOC_CAL_6 @ 0x218;
    reg {
        field {
            sw = rw;
            hw = r;
            desc = "Whole-register value; individual fields are not yet documented";
        } VALUE[31:0] = 0x0;
    } CFG_DCOC_CAL_7 @ 0x21C;
    reg {
        field {
            sw = rw;
            hw = r;
            desc = "Whole-register value; individual fields are not yet documented";
        } VALUE[31:0] = 0x0;
    } CFG_DCOC_CAL_8 @ 0x220;
    reg {
        field {
            sw = rw;
            hw = r;
            desc = "Whole-register value; individual fields are not yet documented";
        } VALUE[31:0] = 0x0;
    } RPT_DCOC_CAL_0 @ 0x224;
    reg {
        field {
            sw = rw;
            hw = r;
            desc = "Whole-register value; individual fields are not yet documented";
        } VALUE[31:0] = 0x0;
    } CFG_DCOC_CAL_12 @ 0x228;
    reg {
        field {
            sw = rw;
            hw = r;
        } cfg_manual_preamp_os_code[5:0] = 0x0;
        field {
            sw = rw;
            hw = r;
        } cfg_manual_preamp_os_update[8:8] = 0x0;
    } CFG_DCOC_CAL_13 @ 0x22C;
    reg {
        field {
            sw = rw;
            hw = r;
            desc = "Whole-register value; individual fields are not yet documented";
        } VALUE[31:0] = 0x0;
    } RPT_DCOC_CAL_1 @ 0x230;
    reg {
        field {
            sw = rw;
            hw = r;
            desc = "Whole-register value; individual fields are not yet documented";
        } VALUE[31:0] = 0x0;
    } CFG_SAR_SPD_0 @ 0x240;
    reg {
        field {
            sw = rw;
            hw = r;
            desc = "Whole-register value; individual fields are not yet documented";
        } VALUE[31:0] = 0x0;
    } CFG_SAR_SPD_1 @ 0x244;
    reg {
        field {
            sw = rw;
            hw = r;
            desc = "Whole-register value; individual fields are not yet documented";
        } VALUE[31:0] = 0x0;
    } CFG_SAR_SPD_2 @ 0x248;
    reg {
        field {
            sw = rw;
            hw = r;
            desc = "Whole-register value; individual fields are not yet documented";
        } VALUE[31:0] = 0x0;
    } CFG_SAR_SPD_3 @ 0x24C;
    reg {
        field {
            sw = rw;
            hw = r;
            desc = "Whole-register value; individual fields are not yet documented";
        } VALUE[31:0] = 0x0;
    } CFG_SAR_SPD_4 @ 0x250;
    reg {
        field {
            sw = rw;
            hw = r;
            desc = "Whole-register value; individual fields are not yet documented";
        } VALUE[31:0] = 0x0;
    } RPT_SAR_SPD_0 @ 0x254;
    reg {
        field {
            sw = rw;
            hw = r;
            desc = "Whole-register value; individual fields are not yet documented";
        } VALUE[31:0] = 0x0;
    } RPT_SAR_SPD_1 @ 0x258;
    reg {
        field {
            sw = rw;
            hw = r;
        } cfg_manual_sar_spd_dly_code[2:0] = 0x0;
        field {
            sw = rw;
            hw = r;
        } cfg_manual_sar_spd_update[4:4] = 0x0;
    } CFG_SAR_SPD_6 @ 0x25C;
    reg {
        field {
            sw = rw;
            hw = r;
            desc = "Whole-register value; individual fields are not yet documented";
        } VALUE[31:0] = 0x0;
    } RPT_SAR_SPD_2 @ 0x260;
    reg {
        field {
            sw = rw;
            hw = r;
            desc = "Whole-register value; individual fields are not yet documented";
        } VALUE[31:0] = 0x0;
    } CFG_RC_CAL_0 @ 0x280;
    reg {
        field {
            sw = rw;
            hw = r;
            desc = "Whole-register value; individual fields are not yet documented";
        } VALUE[31:0] = 0x0;
    } CFG_RC_CAL_1 @ 0x284;
    reg {
        field {
            sw = rw;
            hw = r;
            desc = "Whole-register value; individual fields are not yet documented";
        } VALUE[31:0] = 0x0;
    } CFG_RC_CAL_2 @ 0x288;
    reg {
        field {
            sw = rw;
            hw = r;
            desc = "Whole-register value; individual fields are not yet documented";
        } VALUE[31:0] = 0x0;
    } CFG_RC_CAL_3 @ 0x28C;
    reg {
        field {
            sw = rw;
            hw = r;
            desc = "Whole-register value; individual fields are not yet documented";
        } VALUE[31:0] = 0x0;
    } CFG_RC_CAL_4 @ 0x290;
    reg {
        field {
            sw = rw;
            hw = r;
            desc = "Whole-register value; individual fields are not yet documented";
        } VALUE[31:0] = 0x0;
    } RPT_RC_CAL_0 @ 0x294;
    reg {
        field {
            sw = rw;
            hw = r;
            desc = "Whole-register value; individual fields are not yet documented";
        } VALUE[31:0] = 0x0;
    } RPT_RC_CAL_1 @ 0x298;
    reg {
        field {
            sw = rw;
            hw = r;
            desc = "Whole-register value; individual fields are not yet documented";
        } VALUE[31:0] = 0x0;
    } CFG_RC_CAL_5 @ 0x29C;
    reg {
        field {
            sw = rw;
            hw = r;
            desc = "Whole-register value; individual fields are not yet documented";
        } VALUE[31:0] = 0x0;
    } CFG_RC_CAL_6 @ 0x2A0;
    reg {
        field {
            sw = rw;
            hw = r;
            desc = "Whole-register value; individual fields are not yet documented";
        } VALUE[31:0] = 0x0;
    } CFG_RC_CAL_7 @ 0x2A4;
    reg {
        field {
            sw = rw;
            hw = r;
            desc = "Whole-register value; individual fields are not yet documented";
        } VALUE[31:0] = 0x0;
    } CFG_RC_CAL_8 @ 0x2A8;
    reg {
        field {
            sw = rw;
            hw = r;
            desc = "Whole-register value; individual fields are not yet documented";
        } VALUE[31:0] = 0x0;
    } RPT_RC_CAL_2 @ 0x2AC;
    reg {
        field {
            sw = rw;
            hw = r;
            desc = "Whole-register value; individual fields are not yet documented";
        } VALUE[31:0] = 0x0;
    } RPT_RC_CAL_3 @ 0x2B0;
    reg {
        field {
            sw = rw;
            hw = r;
            desc = "Whole-register value; individual fields are not yet documented";
        } VALUE[31:0] = 0x0;
    } CFG_AMUX_0 @ 0x2C0;
    reg {
        field {
            sw = rw;
            hw = r;
        } amuxn_sensor_ch_sel[10:0] = 0x0;
        field {
            sw = rw;
            hw = r;
        } amuxn_devide_disable[11:11] = 0x0;
        field {
            sw = rw;
            hw = r;
        } amuxp_sensor_ch_sel[22:12] = 0x0;
        field {
            sw = rw;
            hw = r;
        } amuxp_devide_disable[23:23] = 0x0;
    } CFG_AMUX_1 @ 0x2C4;
    reg {
        field {
            sw = rw;
            hw = r;
        } cfg_amuxn_audio_ch_sel[3:0] = 0x0;
        field {
            sw = rw;
            hw = r;
        } cfg_amuxp_audio_ch_sel[7:4] = 0x0;
    } CFG_AMUX_2 @ 0x2C8;
    reg {
        field {
            sw = rw;
            hw = r;
            desc = "Whole-register value; individual fields are not yet documented";
        } VALUE[31:0] = 0x0;
    } CFG_AMUX_3 @ 0x2CC;
    reg {
        field {
            sw = rw;
            hw = r;
            desc = "Whole-register value; individual fields are not yet documented";
        } VALUE[31:0] = 0x0;
    } CFG_AMUX_4 @ 0x2D0;
    reg {
        field {
            sw = rw;
            hw = r;
            desc = "Whole-register value; individual fields are not yet documented";
        } VALUE[31:0] = 0x0;
    } CFG_AMUX_5 @ 0x2D4;
    reg {
        field {
            sw = rw;
            hw = r;
            desc = "Whole-register value; individual fields are not yet documented";
        } VALUE[31:0] = 0x0;
    } RPT_AMUX_0 @ 0x2D8;
    reg {
        field {
            sw = rw;
            hw = r;
            desc = "Whole-register value; individual fields are not yet documented";
        } VALUE[31:0] = 0x0;
    } CFG_TST_0 @ 0x2F0;
    reg {
        field {
            sw = rw;
            hw = r;
        } diag_node[2:0] = 0x0;
    } CFG_TST_1 @ 0x2F4;
    reg {
        field {
            sw = rw;
            hw = r;
            desc = "Whole-register value; individual fields are not yet documented";
        } VALUE[31:0] = 0x0;
    } CFG_CMP_0 @ 0x2F8;
    reg {
        field {
            sw = rw;
            hw = r;
            desc = "Whole-register value; individual fields are not yet documented";
        } VALUE[31:0] = 0x0;
    } CFG_CMP_1 @ 0x2FC;
    reg {
        field {
            sw = rw;
            hw = r;
            desc = "Whole-register value; individual fields are not yet documented";
        } VALUE[31:0] = 0x0;
    } RPT_CMP_0 @ 0x300;
    reg {
        field {
            sw = rw;
            hw = r;
            desc = "Whole-register value; individual fields are not yet documented";
        } VALUE[31:0] = 0x0;
    } RPT_CMP_1 @ 0x304;
    reg {
        field {
            sw = rw;
            hw = r;
            desc = "Whole-register value; individual fields are not yet documented";
        } VALUE[31:0] = 0x0;
    } CFG_RX_SCRATCH @ 0x3D0;
    reg {
        field {
            sw = rw;
            hw = r;
        } cfg_topbias_en[0:0] = 0x0;
        field {
            sw = rw;
            hw = r;
        } cfg_vrefldo_en_test[4:4] = 0x0;
        field {
            sw = rw;
            hw = r;
        } cfg_vrefldo_en_sw[8:8] = 0x0;
        field {
            sw = rw;
            hw = r;
        } cfg_vrefldo_en_hiz[12:12] = 0x0;
        field {
            sw = rw;
            hw = r;
        } cfg_vrefldo_en_dly[16:16] = 0x0;
        field {
            sw = rw;
            hw = r;
        } cfg_vrefldo_en[20:20] = 0x0;
        field {
            sw = rw;
            hw = r;
        } cfg_clk_rstn[24:24] = 0x0;
    } CFG_ANA_0 @ 0x3D4;
    reg {
        field {
            sw = rw;
            hw = r;
        } cfg_preamp_os_dac_en[0:0] = 0x0;
        field {
            sw = rw;
            hw = r;
        } cfg_pga_vcm_en[4:4] = 0x0;
        field {
            sw = rw;
            hw = r;
        } cfg_pga_en[8:8] = 0x0;
        field {
            sw = rw;
            hw = r;
        } cfg_preamp_vcm_en[12:12] = 0x0;
        field {
            sw = rw;
            hw = r;
        } cfg_preamp_en[16:16] = 0x0;
        field {
            sw = rw;
            hw = r;
        } cfg_tsensor_en[20:20] = 0x0;
        field {
            sw = rw;
            hw = r;
        } cfg_bufp_en[24:24] = 0x0;
        field {
            sw = rw;
            hw = r;
        } cfg_bufn_en[28:28] = 0x0;
    } CFG_ANA_1 @ 0x3D8;
    reg {
        field {
            sw = rw;
            hw = r;
        } cfg_cmp_vin_rdac_code[5:0] = 0x0;
        field {
            sw = rw;
            hw = r;
        } cfg_cmp_vin_rdac_ref_sel[10:8] = 0x0;
        field {
            sw = rw;
            hw = r;
        } cfg_cmp_en[12:12] = 0x0;
    } CFG_ANA_2 @ 0x3DC;
    reg {
        field {
            sw = rw;
            hw = r;
            desc = "Whole-register value; individual fields are not yet documented";
        } VALUE[31:0] = 0x0;
    } CFG_ANA_3 @ 0x3E0;
    reg {
        field {
            sw = rw;
            hw = r;
        } cfg_afe_adcldo_en[0:0] = 0x0;
    } CFG_ANA_4 @ 0x3E4;
    reg {
        field {
            sw = rw;
            hw = r;
        } cfg_afe_adcldo_vset[3:0] = 0x0;
        field {
            sw = rw;
            hw = r;
        } cfg_afe_adcldo_rpoly_trim[7:4] = 0x0;
        field {
            sw = rw;
            hw = r;
        } cfg_afe_adcldo_idummy_trim[9:8] = 0x0;
        field {
            sw = rw;
            hw = r;
        } cfg_afe_adcldo_ictr_trim[14:12] = 0x0;
        field {
            sw = rw;
            hw = r;
        } cfg_afe_adcldo_en_test[16:16] = 0x0;
        field {
            sw = rw;
            hw = r;
        } cfg_afe_adcldo_en_sw[20:20] = 0x0;
        field {
            sw = rw;
            hw = r;
        } cfg_afe_adcldo_en_hiz[24:24] = 0x0;
        field {
            sw = rw;
            hw = r;
        } cfg_afe_adcldo_en_dly[28:28] = 0x0;
    } CFG_ANA_5 @ 0x3E8;
    reg {
        field {
            sw = rw;
            hw = r;
        } cfg_afe_afeldo_en[0:0] = 0x0;
    } CFG_ANA_6 @ 0x3EC;
    reg {
        field {
            sw = rw;
            hw = r;
        } cfg_afe_afeldo_vset[3:0] = 0x0;
        field {
            sw = rw;
            hw = r;
        } cfg_afe_afeldo_rpoly_trim[7:4] = 0x0;
        field {
            sw = rw;
            hw = r;
        } cfg_afe_afeldo_idummy_trim[9:8] = 0x0;
        field {
            sw = rw;
            hw = r;
        } cfg_afe_afeldo_ictr_trim[14:12] = 0x0;
        field {
            sw = rw;
            hw = r;
        } cfg_afe_afeldo_en_test[16:16] = 0x0;
        field {
            sw = rw;
            hw = r;
        } cfg_afe_afeldo_en_sw[20:20] = 0x0;
        field {
            sw = rw;
            hw = r;
        } cfg_afe_afeldo_en_hiz[24:24] = 0x0;
        field {
            sw = rw;
            hw = r;
        } cfg_afe_afeldo_en_dly[28:28] = 0x0;
    } CFG_ANA_7 @ 0x3F0;
    reg {
        field {
            sw = rw;
            hw = r;
        } cfg_vrefldo_ictr_trim[2:0] = 0x0;
        field {
            sw = rw;
            hw = r;
        } cfg_vrefldo_idummy_trim[4:3] = 0x0;
        field {
            sw = rw;
            hw = r;
        } cfg_vrefldo_rpoly_trim[8:5] = 0x0;
        field {
            sw = rw;
            hw = r;
        } cfg_vrefldo_vset_trim[12:9] = 0x0;
        field {
            sw = rw;
            hw = r;
        } cfg_vrefldo_reserved[15:13] = 0x0;
    } CFG_FREG_0 @ 0x3F4;
    reg {
        field {
            sw = rw;
            hw = r;
            desc = "Whole-register value; individual fields are not yet documented";
        } VALUE[31:0] = 0x0;
    } CFG_FREG_1 @ 0x3F8;
    reg {
        field {
            sw = rw;
            hw = r;
            desc = "Whole-register value; individual fields are not yet documented";
        } VALUE[31:0] = 0x0;
    } CFG_FREG_2 @ 0x3FC;
    reg {
        field {
            sw = rw;
            hw = r;
        } cfg_preamp_gain_sel[7:0] = 0x0;
        field {
            sw = rw;
            hw = r;
        } cfg_preamp_bypass_en[8:8] = 0x0;
        field {
            sw = rw;
            hw = r;
        } cfg_preamp_rc_en[9:9] = 0x0;
        field {
            sw = rw;
            hw = r;
        } cfg_preamp_vip_short[10:10] = 0x0;
        field {
            sw = rw;
            hw = r;
        } cfg_preamp_vin_short[11:11] = 0x0;
    } CFG_FREG_3 @ 0x400;
    reg {
        field {
            sw = rw;
            hw = r;
        } cfg_preamp_vocm_ref_sel[3:0] = 0x0;
        field {
            sw = rw;
            hw = r;
        } cfg_preamp_vicm_ref_sel[5:4] = 0x0;
        field {
            sw = rw;
            hw = r;
        } cfg_preamp_ibias_sel[6:6] = 0x0;
        field {
            sw = rw;
            hw = r;
        } cfg_preamp_rz_sel[7:7] = 0x0;
        field {
            sw = rw;
            hw = r;
        } cfg_preamp_cc_sel[8:8] = 0x0;
    } CFG_FREG_4 @ 0x404;
    reg {
        field {
            sw = rw;
            hw = r;
        } cfg_pga_gain_sel[3:0] = 0x0;
        field {
            sw = rw;
            hw = r;
        } cfg_pga_chop_mode_sel[5:4] = 0x0;
        field {
            sw = rw;
            hw = r;
        } cfg_pga_bypass_en[6:6] = 0x0;
        field {
            sw = rw;
            hw = r;
        } cfg_pga_rc_en[7:7] = 0x0;
    } CFG_FREG_5 @ 0x408;
    reg {
        field {
            sw = rw;
            hw = r;
        } cfg_pga_vocm_ref_sel[2:0] = 0x0;
        field {
            sw = rw;
            hw = r;
        } cfg_pga_ibias_sel[4:3] = 0x0;
        field {
            sw = rw;
            hw = r;
        } cfg_pga_rz_sel[6:5] = 0x0;
        field {
            sw = rw;
            hw = r;
        } cfg_pga_cc_sel[9:7] = 0x0;
    } CFG_FREG_6 @ 0x40C;
    reg {
        field {
            sw = rw;
            hw = r;
        } cfg_idac_sel_pga[0:0] = 0x0;
        field {
            sw = rw;
            hw = r;
        } cfg_idac_sel_preamp[1:1] = 0x0;
        field {
            sw = rw;
            hw = r;
        } cfg_chopclk_div_dly_sel[3:2] = 0x0;
        field {
            sw = rw;
            hw = r;
        } cfg_chopclk_div_freq_sel[5:4] = 0x0;
        field {
            sw = rw;
            hw = r;
        } cfg_topbias_trim[15:6] = 0x0;
    } CFG_FREG_7 @ 0x410;
    reg {
        field {
            sw = rw;
            hw = r;
            desc = "Whole-register value; individual fields are not yet documented";
        } VALUE[31:0] = 0x0;
    } CFG_FREG_8 @ 0x414;
    reg {
        field {
            sw = rw;
            hw = r;
            desc = "Whole-register value; individual fields are not yet documented";
        } VALUE[31:0] = 0x0;
    } CFG_FREG_9 @ 0x418;
    reg {
        field {
            sw = rw;
            hw = r;
        } cfg_gadc_short_mode[0:0] = 0x0;
        field {
            sw = rw;
            hw = r;
        } cfg_gadc_vcm_mode[1:1] = 0x0;
        field {
            sw = rw;
            hw = r;
        } cfg_gadc_dly2inject[2:2] = 0x0;
        field {
            sw = rw;
            hw = r;
        } cfg_gadc_dly2convrstn[4:3] = 0x0;
        field {
            sw = rw;
            hw = r;
        } cfg_gadc_dly2convstart[6:5] = 0x0;
        field {
            sw = rw;
            hw = r;
        } cfg_gadc_dly2srwidth[8:7] = 0x0;
        field {
            sw = rw;
            hw = r;
        } cfg_gadc_chop_en[11:9] = 0x0;
        field {
            sw = rw;
            hw = r;
        } cfg_gadc_chop_freq[12:12] = 0x0;
        field {
            sw = rw;
            hw = r;
        } cfg_gadc_lsbrpts_en[13:13] = 0x0;
        field {
            sw = rw;
            hw = r;
        } cfg_gadc_r_sel_fall[14:14] = 0x0;
    } CFG_FREG_10 @ 0x41C;
    reg {
        field {
            sw = rw;
            hw = r;
        } cfg_gadc_r_sel_rise[2:0] = 0x0;
        field {
            sw = rw;
            hw = r;
        } cfg_gadc_meta_det_en[3:3] = 0x0;
        field {
            sw = rw;
            hw = r;
        } cfg_gadc_meta_det_trim[5:4] = 0x0;
        field {
            sw = rw;
            hw = r;
        } cfg_gadc_os_range_sel[6:6] = 0x0;
        field {
            sw = rw;
            hw = r;
        } cfg_dreg_iso_enb[15:15] = 0x0;
    } CFG_FREG_11 @ 0x420;
};