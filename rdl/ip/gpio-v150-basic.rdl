// Active GPIO v150 basic layout shared by WS53, WS63 and BS2X. None of the
// audited product configurations enables CONFIG_GPIO_SUPPORT_MULTISYSTEM.

addrmap gpio_v150_basic_regs {
    reg {
        field {
            sw = rw;
            hw = r;
            desc = "GPIO data. Output: written value drives I/O; Input: reads external port";
        } gpio_sw_out[7:0] = 0x0;
    } GPIO_SW_OUT @ 0x0;
    reg {
        field {
            enum GPIO0_GPIO_SW_OEN_gpio_sw_oen_e1 {
                Output = 0 {
                    desc = "Output direction";
                };
                Input = 1 {
                    desc = "Input direction";
                };
            } ;
            sw = rw;
            hw = r;
            encode = GPIO0_GPIO_SW_OEN_gpio_sw_oen_e1;
            desc = "GPIO direction: 0=output; 1=input (default)";
        } gpio_sw_oen[7:0] = 0xFF;
    } GPIO_SW_OEN @ 0x4;
    reg {
        field {
            sw = rw;
            hw = r;
            desc = "Interrupt enable: 0=normal GPIO; 1=interrupt port";
        } gpio_int_en[7:0] = 0x0;
    } GPIO_INT_EN @ 0xC;
    reg {
        field {
            sw = rw;
            hw = r;
            desc = "Interrupt mask: 0=not masked; 1=masked";
        } gpio_int_mask[7:0] = 0x0;
    } GPIO_INT_MASK @ 0x10;
    reg {
        field {
            enum GPIO0_GPIO_INT_TYPE_gpio_int_type_e2 {
                Level = 0 {
                    desc = "Level-sensitive";
                };
                Edge = 1 {
                    desc = "Edge-triggered";
                };
            } ;
            sw = rw;
            hw = r;
            encode = GPIO0_GPIO_INT_TYPE_gpio_int_type_e2;
            desc = "Interrupt type: 0=level; 1=edge";
        } gpio_int_type[7:0] = 0x0;
    } GPIO_INT_TYPE @ 0x14;
    reg {
        field {
            enum GPIO0_GPIO_INT_POLARITY_gpio_int_polarity_e3 {
                LowFalling = 0 {
                    desc = "Low level or falling edge";
                };
                HighRising = 1 {
                    desc = "High level or rising edge";
                };
            } ;
            sw = rw;
            hw = r;
            encode = GPIO0_GPIO_INT_POLARITY_gpio_int_polarity_e3;
            desc = "Interrupt polarity: 0=low/falling; 1=high/rising";
        } gpio_int_polarity[7:0] = 0x0;
    } GPIO_INT_POLARITY @ 0x18;
    reg {
        field {
            enum GPIO0_GPIO_INT_DEDGE_gpio_int_dedge_e4 {
                Disabled = 0 {
                    desc = "Single-edge mode";
                };
                Enabled = 1 {
                    desc = "Dual-edge triggered";
                };
            } ;
            sw = rw;
            hw = r;
            encode = GPIO0_GPIO_INT_DEDGE_gpio_int_dedge_e4;
            desc = "Dual-edge interrupt enable: 0=disabled; 1=enabled";
        } gpio_int_dedge[7:0] = 0x0;
    } GPIO_INT_DEDGE @ 0x1C;
    reg {
        field {
            sw = rw;
            hw = r;
            desc = "Debounce enable: 0=disabled; 1=enabled";
        } gpio_int_debounce[7:0] = 0x0;
    } GPIO_INT_DEBOUNCE @ 0x20;
    reg {
        field {
            sw = r;
            hw = r;
            desc = "Raw interrupt status (before mask): 0=no interrupt; 1=interrupt";
        } gpio_int_raw[7:0] = 0x0;
    } GPIO_INT_RAW @ 0x24;
    reg {
        field {
            sw = r;
            hw = r;
            desc = "Interrupt status (after mask): 0=no interrupt; 1=interrupt";
        } gpio_intr[7:0] = 0x0;
    } GPIO_INTR @ 0x28;
    reg {
        field {
            sw = w;
            hw = r;
            desc = "Edge interrupt clear: 0=no clear; 1=clear interrupt";
        } gpio_int_eoi[7:0] = 0x0;
    } GPIO_INT_EOI @ 0x2C;
    reg {
        field {
            sw = w;
            hw = r;
            desc = "Write 1 to set corresponding GPIO_SW_OUT bits";
        } gpio_data_set[7:0] = 0x0;
    } GPIO_DATA_SET @ 0x30;
    reg {
        field {
            sw = w;
            hw = r;
            desc = "Write 1 to clear corresponding GPIO_SW_OUT bits";
        } gpio_data_clr[7:0] = 0x0;
    } GPIO_DATA_CLR @ 0x34;
};
