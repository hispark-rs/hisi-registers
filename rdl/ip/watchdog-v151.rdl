// Shared HiSilicon watchdog v151 register block.
// Confirmed by byte-identical register definition and operation headers in
// fbb_ws53, fbb_ws63 and fbb_bs2x.

// SDK_VIEW separates asymmetric command/status words. The default preserves
// existing WS63/BS2X output until their consumers are migrated explicitly.
addrmap watchdog_v151_regs #(bit SDK_VIEW = false) {
    reg {
        field {
            sw = w;
            hw = r;
            desc = "Write 0x5A5A5A5A to unlock, other values lock";
        } wdt_lock[31:0] = 0x0;
    } WDT_LOCK @ 0x0;
    WDT_LOCK->ispresent = !SDK_VIEW;
    reg {
        field { sw=r; hw=w; desc="0 unlocked, 1 locked; not the last written key"; } locked[0:0];
    } LOCK_STATUS @ 0x0;
    LOCK_STATUS->ispresent = SDK_VIEW;
    reg {
        hisi_svd_alternate_register = "LOCK_STATUS";
        field { sw=w; hw=r; desc="0x5A5A5A5A unlocks; any other value locks"; } key[31:0];
    } LOCK_COMMAND @ 0x0;
    LOCK_COMMAND->ispresent = SDK_VIEW;
    reg {
        field {
            sw = rw;
            hw = r;
            desc = "Load count value (24-bit, low 8 bits reserved)";
        } wdt_load[31:8] = 0x0;
    } WDT_LOAD @ 0x4;
    reg {
        field {
            sw = w;
            hw = r;
            desc = "Write anything except 0x5A5A5A5A to restart counter";
        } wdt_restart[31:0] = 0x0;
    } WDT_RESTART @ 0x8;
    external reg {
        field {
            sw = r;
            hw = r;
            desc = "Read to clear watchdog interrupt";
        } wdt_eoi[0:0] = 0x0;
    } WDT_EOI @ 0xC;
    reg {
        field {
            sw = rw;
            hw = r;
            desc = "Watchdog enable: 0=disabled; 1=enabled";
        } wdt_en[0:0] = 0x0;
        field {
            sw = rw;
            hw = r;
            desc = "Reset enable: 0=no reset on timeout; 1=reset on timeout";
        } rst_en[2:2] = 0x0;
        field {
            sw = rw;
            hw = r;
            desc = "Reset pulse length: 000=2 clocks; up to 111=256 clocks";
        } rst_pl[5:3] = 0x0;
        field {
            sw = rw;
            hw = r;
            desc = "Interrupt mask: 0=unmasked; 1=masked";
        } wdt_imsk[6:6] = 0x0;
        field {
            enum WDT_WDT_CR_wdt_mode_e1 {
                Mode1 = 0 {
                    desc = "Single interrupt then reset";
                };
                Mode2 = 1 {
                    desc = "Two interrupts then reset";
                };
            } ;
            sw = rw;
            hw = r;
            encode = WDT_WDT_CR_wdt_mode_e1;
            desc = "Mode: 0=one interrupt then reset; 1=two interrupts then reset";
        } wdt_mode[7:7] = 0x0;
    } WDT_CR @ 0x10;
    reg {
        field {
            sw = r;
            hw = r;
            desc = "Current counter value";
        } wdt_cnt[31:0] = 0x0;
    } WDT_CNT @ 0x14;
    reg {
        field {
            sw = r;
            hw = r;
            desc = "Raw interrupt status";
        } wdt_raw_intr[0:0] = 0x0;
    } WDT_RAW_INTR @ 0x18;
    reg {
        field {
            sw = r;
            hw = r;
            desc = "Interrupt status after mask";
        } wdt_intr[0:0] = 0x0;
    } WDT_INTR @ 0x1C;
    reg {
        field {
            sw = r;
            hw = r;
            desc = "Low power interface state";
        } wdt_lpif_state[2:0] = 0x0;
    } WDT_LPIF_STATE @ 0x20;
    reg {
        field {
            sw = r;
            hw = r;
            desc = "Status: 0=busy; 1=free";
        } wdt_status[0:0] = 0x0;
    } WDT_STATUS @ 0x24;
    reg {
        field {
            sw = w;
            hw = r;
            desc = "Write 1 to request current counter value";
        } ccvr_req[0:0] = 0x0;
        field {
            sw = r;
            hw = r;
            desc = "Acknowledge: 1=counter value valid";
        } ccvr_ack[1:1] = 0x0;
    } WDT_CCVR_EN @ 0x28;
    WDT_CCVR_EN->ispresent = !SDK_VIEW;
    reg {
        field { sw=r; hw=w; desc="Counter latch valid; inspect after requesting a snapshot"; } valid[1:1];
    } CCVR_STATUS @ 0x28;
    CCVR_STATUS->ispresent = SDK_VIEW;
    reg {
        hisi_svd_alternate_register = "CCVR_STATUS";
        field { sw=w; hw=r; hisi_write_min=1; hisi_write_max=1; } request[0:0];
    } CCVR_REQUEST @ 0x28;
    CCVR_REQUEST->ispresent = SDK_VIEW;
};
