// fbb_ws53 163d9150: drivers/chips/ws53/dyn_mem/dyn_mem.c and
// include/clock_recover.h. Shared system state, never an acore-exclusive token.
// Reset values are unknown. Domain release is an explicit shared-resource
// operation; it is not part of the default RAM takeover.
addrmap ws53_system_memory_regs {
    hisi_evidence = "SDK source: dyn_mem.c bram_share_cfg_t/acore_idtcm_dyn_cfg/acore_dtcm_dyn_cfg; shared acore/ccore; no reset values verified";
    reg {
        regwidth=16; accesswidth=16;
        hisi_svd_word_view="GPIO_CLOCK_WORD";
        hisi_evidence="SDK 163d9150 ws53_application/main.c dev_work_clock_init unconditionally uses reg16_setbit(0x57030024,0), including BOARD_ASIC. clock_recover.c and pm_porting.c also use word writes 1/3/0. Shared AGPIO/ULP clock; reset value and silicon timing are unknown. SPI23 Flash failure reaches the GPIO1 access stage while factory-initialized RAM works; this is not yet controlled gate-causality proof";
        field {sw=rw; hw=r;
            desc="SDK AGPIO clock enable; application initialization sets bit0 before GPIO1 use. Preserve the handed-off source and other clock bits. Shared with sleep/wakeup code; no automatic disable or exclusive ownership is implied";
        } enable[0:0];
        field {sw=rw; hw=r;
            desc="SDK clock recovery writes 3 for GPIO 32K and 1 for PLL/fast source. Frequency, APB versus interrupt-clock coverage, and low-power behavior remain silicon-unqualified";
        } slow_clock_select[1:1];
    } GPIO_CLOCK @ 0x24;
    reg {
        field { sw=rw; hw=r; desc="RAM6/7,8/9,10/11,12/13: 0 acore, 1 ccore"; } owner[3:0];
        field { sw=rw; hw=r; desc="One clock gate per shared RAM pair"; } clock_enable[7:4];
        field { sw=rw; hw=r; desc="Ccore shared RAM address offset"; } ccore_offset[11:8];
    } BRAM_SHARE @ 0x234;
    reg {
        field { sw=rw; hw=r; desc="RAM0..5: 0 ITCM, 1 DTCM"; } dtcm_select[5:0];
    } DTCM_SHARE @ 0x238;
    reg {
        field { sw=rw; hw=r; desc="MCU mode encoded bits: mode1=0, mode2=1, mode3=2, mode4=4"; } mcu_mode[8:6];
    } PLATFORM_ENABLE @ 0x604;
    reg {
        name = "Control-core reset observation; no reset command is exposed by this view";
        hisi_evidence = "SDK 163d9150 acore/platform_core.h HAL_SOFT_RST_2_GLB_B/RESET_CRG_CCORE_VALUE/RESET_CCORE_VALUE; main.c copy_to_ccore: 0 all held, 3 logic/clock released, 7 CPU also released. Physical-SRST app-entry observation 2026-10-24 reads 0; not a silicon reset-value claim";
        field { sw=r; hw=w; desc="Known domain-release encoding: 0 all held, 3 logic/clock released, 7 CPU also released; other encodings unqualified"; } released_domains[2:0];
    } CCORE_RESET_STATUS @ 0x96c;
    reg {
        hisi_svd_alternate_register = "CCORE_RESET_STATUS";
        name = "Restricted full-word logic/clock release command, retaining control CPU reset";
        hisi_evidence = "SDK 163d9150 acore/platform_core.h HAL_SOFT_RST_2_GLB_B=0x5703096c, RESET_CRG_CCORE_VALUE=3; main.c copy_to_ccore writes the complete word 3 then delays 5us before accessing the domain. Board 2026-10-25 diagnostic 0->3 makes TSENSOR CONTROL/STATUS readable as zero; writing zero again then reading that domain stalled debug. Do not expose generic reset or CPU release from this view";
        field {
            sw=w; hw=r;
            hisi_write_min=3; hisi_write_max=3;
            desc="Write exactly 3 after exclusive domain handoff from state0, wait at least SDK 5us and verify status3; CPU bit2 stays zero. This is a shared domain, not just TSENSOR. Reset state and other command values are not modeled; SVD constraints do not guard unsafe raw PAC writes";
        } logic_clock_release[31:0];
    } CCORE_LOGIC_CLOCK_RELEASE_COMMAND @ 0x96c;
};
