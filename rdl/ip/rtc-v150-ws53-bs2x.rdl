// Shared by WS53 and BS2X. Their fbb SDK v150 register definitions are
// semantically identical; chip maps retain instance addresses and IRQs.

addrmap rtc_v150_ws53_bs2x_regs {
    reg {
        field {
            sw = rw;
            hw = r;
        } load_count0[31:0] = 0x0;
    } LOAD_COUNT0 @ 0x0;
    reg {
        field {
            sw = rw;
            hw = r;
        } load_count1[31:0] = 0x0;
    } LOAD_COUNT1 @ 0x4;
    reg {
        field {
            sw = r;
            hw = r;
        } current_value0[31:0] = 0x0;
    } CURRENT_VALUE0 @ 0x8;
    reg {
        field {
            sw = r;
            hw = r;
        } current_value1[31:0] = 0x0;
    } CURRENT_VALUE1 @ 0xC;
    reg {
        field {
            sw = rw;
            hw = r;
        } enable[0:0] = 0x0;
        field {
            sw = rw;
            hw = r;
        } mode[2:1] = 0x0;
        field {
            sw = rw;
            hw = r;
        } int_mask[3:3] = 0x0;
        field {
            sw = rw;
            hw = r;
        } rstfsm[4:4] = 0x0;
        field {
            sw = rw;
            hw = r;
        } cnt_req[5:5] = 0x0;
        field {
            sw = rw;
            hw = r;
        } cnt_lock[6:6] = 0x0;
    } CONTROL @ 0x10;
    reg {
        field {
            sw = rw;
            hw = r;
        } eoi[0:0] = 0x0;
    } EOI_REN @ 0x14;
    reg {
        field {
            sw = rw;
            hw = r;
        } int_status[0:0] = 0x0;
    } RAW_INTR @ 0x18;
    reg {
        field {
            sw = rw;
            hw = r;
        } int_status[0:0] = 0x0;
    } INTR @ 0x1C;
};
