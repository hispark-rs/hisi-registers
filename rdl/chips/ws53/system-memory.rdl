// fbb_ws53 163d9150: drivers/chips/ws53/dyn_mem/dyn_mem.c and
// include/clock_recover.h. Shared system state, never an acore-exclusive token.
// Reset values are unknown. RAM takeover reads these; it does not rewrite them.
addrmap ws53_system_memory_regs {
    hisi_evidence = "SDK source: dyn_mem.c bram_share_cfg_t/acore_idtcm_dyn_cfg/acore_dtcm_dyn_cfg; shared acore/ccore; no reset values verified";
    reg {
        field { sw=rw; hw=r; desc="RAM6/7,8/9,10/11,12/13: 0 acore, 1 ccore"; } owner[3:0];
        field { sw=rw; hw=r; desc="One clock gate per shared RAM pair"; } clock_enable[7:4];
        field { sw=rw; hw=r; desc="Ccore shared RAM address offset"; } ccore_offset[11:8];
    } BRAM_SHARE @ 0x234;
    reg {
        field { sw=rw; hw=r; desc="RAM0..5: 0 ITCM, 1 DTCM"; } dtcm_select[5:0];
    } DTCM_SHARE @ 0x238;
    reg {
        field { sw=rw; hw=r; desc="MCU mode encoded bits: mode1=0, mode2=1, mode3=2, mode4=4"; } mcu_mode[8:6];
    } PLATFORM_ENABLE @ 0x604;
    reg {
        name = "Control-core reset observation; no reset command is exposed by this view";
        hisi_evidence = "SDK 163d9150 acore/platform_core.h HAL_SOFT_RST_2_GLB_B/RESET_CRG_CCORE_VALUE/RESET_CCORE_VALUE; main.c copy_to_ccore: 0 all held, 3 logic/clock released, 7 CPU also released. Physical-SRST app-entry observation 2026-10-24 reads 0; not a silicon reset-value claim";
        field { sw=r; hw=w; desc="Known domain-release encoding: 0 all held, 3 logic/clock released, 7 CPU also released; other encodings unqualified"; } released_domains[2:0];
    } CCORE_RESET_STATUS @ 0x96c;
};
